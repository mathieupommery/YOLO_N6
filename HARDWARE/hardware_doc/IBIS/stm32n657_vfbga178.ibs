| IBIS file stm32n657_vfbga178.ibs
[IBIS ver] 4.2
[File name] stm32n657_vfbga178.ibs
[File Rev] 1.1
[Date] 20-09-2024
[Source] Data Created at STMicroelectronics
[Notes]  File originated from ELDO simulations.
[Disclaimer]  This information is for modeling purpose only and is
   not guaranteed. The information is subject to change without
   notice.
[Copyright] Copyright 2024 STMicroelectronics Inc.
|   Component stm32n657_vfbga178
[Component] stm32n657_vfbga178
[Manufacturer] STMicroelectronics
[Package]
| variable   typ   min   max
R_pkg  0  NA  NA
L_pkg  0  NA  NA
C_pkg  0  NA  NA
[Pin]   signal_name   model_name
A1  PDR_ON  nc
A2  OTG2_HSDM  USB2_HS_IBIS
A3  NC  nc
A4  VDD33USB  power
A5  OTG1_HSDM  USB2_HS_IBIS
A6  UCPD1_CC1  nc
A7  PH1-OSC_OUT  isudq_tt
A8  PC6  io8_tt
A9  PC7  io8_tt
A10  PE6  io8_tt_i3c
A11  PD6  io8_tt
A12  PD0  io8_tt
A13  PD3  io8_tt_i3c
A14  VSS  gnd
B1  PC14  io8_tt_sw
B2  OTG2_HSDP  USB2_HS_IBIS
B3  OTG1_ID  nc
B4  OTG2_TXRTUNE  nc
B5  OTG1_HSDP  USB2_HS_IBIS
B6  UCPD1_CC2  nc
B7  PH0-OSC_IN  isudq_tt
B8  PC1  io8_tt_i3c
B9  PE11  io8_tt
B10  PE15  io8_tt_i3c
B11  PD7  io8_tt
B12  PD1  io8_tt
B13  PD4  io8_tt_i3c
B14  PE9  io8_tt
C1  PC15-OSC32_OUT  io8_tt_sw
C2  VBAT  power
C3  PC13  io8_tt_tamp
C4  NC  nc
C5  OTG2_ID  nc
C6  PC8  io8_tt_i3c
C7  PC11  io8_tt_i3c
C8  PH9  io8_tt_i3c
C9  PE14  io8_tt_i3c
C10  PE13  io8_tt_i3c
C11  PD10  io8_tt
C12  PD15  io8_tt_i3c
C13  PE8  io8_tt
C14  PE10  io8_tt
D1  V08CAP  nc
D2  VFBSMPS  nc
D3  BOOT0  isudq_tt
D4  VDDA18USB  power
D5  OTG1_TXRTUNE  nc
D6  PC9  io8_tt_i3c
D7  PC12  io8_tt
D8  PC10  io8_tt_i3c
D9  PE5  io8_tt_i3c
D10  PE12  io8_tt
D11  PE7  io8_tt
D12  PD14  io8_tt_i3c
D13  PD8  io8_tt
D14  PD5  io8_tt
E1  VDDA18PMU  nc
E2  VSSAPMU  nc
E3  PWR_ON  io8_tt
E4  NRST  ioreset_tt_v18_1v8
E5  VDDA18AON  nc
E6  PH2  io8_tt
E7  VSS  gnd
E8  VDDIO4  power
E9  VDDIO4  power
E10  PD2  io8_tt
E11  PD12  io8_tt
E12  PB3  io8_tt
E13  PB2  io8_tt
E14  PD13  io8_tt
F1  VSSSMPS  nc
F2  VSSSMPS  nc
F3  VSSSMPS  nc
F4  VSSSMPS  nc
F5  VSSAON  nc
F10  VSS  gnd
F11  PD11  io8_tt_i3c
F12  PE0  io8_tt
F13  PE1  io8_tt
F14  PE2  io8_tt
G1  VLXSMPS  nc
G2  VLXSMPS  nc
G3  VLXSMPS  nc
G4  VLXSMPS  nc
G10  VDD  power
G11  VDD  power
G12  VDD  power
G13  PE3  io8_tt
G14  PB0  io8_tt
H1  VDDSMPS  nc
H2  VDDSMPS  nc
H3  VDDSMPS  nc
H4  VDDSMPS  nc
H10  VSS  gnd
H11  VSS  gnd
H12  PD9  io8_tt
H13  PB7  io8_tt
H14  PB6  io8_tt
J1  PF4  io8_tt
J2  PF6  io8_tt
J3  PF10  io8_tt
J4  PF5  io8_tt
J5  PF3  io8_tt
J10  VDDIO3  power
J11  VDDIO3  power
J12  PN12  io8_tt
J13  PN4  io8_tt
J14  PN8  io8_tt
K1  PF2  io8_tt
K2  PF14  io8_tt
K3  PF15  io8_tt
K4  PF7  io8_tt
K5  VSS  gnd
K6  VDDCORE  nc
K7  VDDCORE  nc
K8  VDDCORE  nc
K9  VDDCORE  nc
K10  VSS  gnd
K11  PA3  io8_tt
K12  PN6  io8_tt
K13  PN7  io8_tt
K14  PN5  io8_tt
L1  PF8  io8_tt
L2  PF11  io8_tt
L3  PF12  io8_tt
L4  VDDA18PLL  nc
L5  PG14  io8_tt
L6  PA12  io8_tt
L7  VDDCORE  nc
L8  PA6  io8_tt_i3c
L9  PA1  io8_tt
L10  PB11  io8_tt_i3c
L11  PB4  io8_tt
L12  PG8  io8_tt
L13  PN2  io8_tt
L14  PN9  io8_tt
M1  VREFP  nc
M2  PF13  io8_tt
M3  VDDA18ADC  nc
M4  VSSA  nc
M5  PG15  io8_tt
M6  PA11  io8_tt
M7  PA9  io8_tt_i3c
M8  PA5  io8_tt_i3c
M9  PG1  io8_tt
M10  PB12  io8_tt_i3c
M11  PB5  io8_tt_i3c
M12  PG0  io8_tt
M13  PN0  io8_tt
M14  PN10  io8_tt
N1  VREFM  nc
N2  CSI_D1N  DPHY_IBIS_L1
N3  CSI_CKN  DPHY_IBIS_L1
N4  CSI_D0N  DPHY_IBIS_L1
N5  CSI_REXT  nc
N6  VDDCSI  nc
N7  PA10  io8_tt
N8  PA2  io8_tt
N9  PG12  io8_tt
N10  PG10  io8_tt
N11  PG2  io8_tt
N12  PA15  io8_tt
N13  PN3  io8_tt
N14  PN11  io8_tt
P1  VSS  gnd
P2  CSI_D1P  DPHY_IBIS_L1
P3  CSI_CKP  DPHY_IBIS_L1
P4  CSI_D0P  DPHY_IBIS_L1
P5  VDDA18CSI  power
P6  PA14  io8_tt
P7  PA13  io8_tt
P8  PA8  io8_tt_i3c
P9  PG13  io8_tt
P10  PA0  io8_tt
P11  PB10  io8_tt_i3c
P12  PA7  io8_tt
P13  PN1  io8_tt
P14  VSS  gnd
[Package Model]   486-fcvfbga-12x12-178-240308
[Pin Mapping]   pulldown_ref   pullup_ref   | Comment
A1  nc  nc
A2  gnd  VDD33USB
A3  nc  nc
A4  nc  VDD33USB
A5  gnd  VDD33USB
A6  nc  nc
A7  gnd  VDD
A8  gnd  VDDIO4
A9  gnd  VDDIO4
A10  gnd  VDD
A11  gnd  VDD
A12  gnd  VDD
A13  gnd  VDD
A14  gnd  nc
B1  gnd  VSW
B2  gnd  VDD33USB
B3  nc  nc
B4  nc  nc
B5  gnd  VDD33USB
B6  nc  nc
B7  gnd  VDD
B8  gnd  VDDIO4
B9  gnd  VDD
B10  gnd  VDD
B11  gnd  VDD
B12  gnd  VDD
B13  gnd  VDD
B14  gnd  VDD
C1  gnd  VSW
C2  nc  VSW
C3  gnd  VSW
C4  nc  nc
C5  nc  nc
C6  gnd  VDDIO4
C7  gnd  VDDIO4
C8  gnd  VDDIO4
C9  gnd  VDD
C10  gnd  VDD
C11  gnd  VDD
C12  gnd  VDD
C13  gnd  VDD
C14  gnd  VDD
D1  nc  nc
D2  nc  nc
D3  gnd  VDD
D4  nc  VDDA18USB
D5  nc  nc
D6  gnd  VDDIO4
D7  gnd  VDDIO4
D8  gnd  VDDIO4
D9  gnd  VDD
D10  gnd  VDD
D11  gnd  VDD
D12  gnd  VDD
D13  gnd  VDD
D14  gnd  VDD
E1  nc  nc
E2  nc  nc
E3  gnd  VDD
E4  gnd  VDD
E5  nc  nc
E6  gnd  VDDIO4
E7  gnd  nc
E8  nc  VDDIO4
E9  nc  VDDIO4
E10  gnd  VDD
E11  gnd  VDD
E12  gnd  VDD
E13  gnd  VDD
E14  gnd  VDD
F1  nc  nc
F2  nc  nc
F3  nc  nc
F4  nc  nc
F5  nc  nc
F10  gnd  nc
F11  gnd  VDD
F12  gnd  VDD
F13  gnd  VDD
F14  gnd  VDD
G1  nc  nc
G2  nc  nc
G3  nc  nc
G4  nc  nc
G10  nc  VDD
G11  nc  VDD
G12  nc  VDD
G13  gnd  VDD
G14  gnd  VDD
H1  nc  nc
H2  nc  nc
H3  nc  nc
H4  nc  nc
H10  gnd  nc
H11  gnd  nc
H12  gnd  VDD
H13  gnd  VDD
H14  gnd  VDD
J1  gnd  VDD
J2  gnd  VDD
J3  gnd  VDD
J4  gnd  VDD
J5  gnd  VDD
J10  nc  VDDIO3
J11  nc  VDDIO3
J12  gnd  VDDIO3
J13  gnd  VDDIO3
J14  gnd  VDDIO3
K1  gnd  VDD
K2  gnd  VDD
K3  gnd  VDD
K4  gnd  VDD
K5  gnd  nc
K6  nc  nc
K7  nc  nc
K8  nc  nc
K9  nc  nc
K10  gnd  nc
K11  gnd  VDD
K12  gnd  VDDIO3
K13  gnd  VDDIO3
K14  gnd  VDDIO3
L1  gnd  VDD
L2  gnd  VDD
L3  gnd  VDD
L4  nc  nc
L5  gnd  VDD
L6  gnd  VDD
L7  nc  nc
L8  gnd  VDD
L9  gnd  VDD
L10  gnd  VDD
L11  gnd  VDD
L12  gnd  VDD
L13  gnd  VDDIO3
L14  gnd  VDDIO3
M1  nc  nc
M2  gnd  VDD
M3  nc  nc
M4  nc  nc
M5  gnd  VDD
M6  gnd  VDD
M7  gnd  VDD
M8  gnd  VDD
M9  gnd  VDD
M10  gnd  VDD
M11  gnd  VDD
M12  gnd  VDD
M13  gnd  VDDIO3
M14  gnd  VDDIO3
N1  nc  nc
N2  gnd  VDDA18CSI
N3  gnd  VDDA18CSI
N4  gnd  VDDA18CSI
N5  nc  nc
N6  nc  nc
N7  gnd  VDD
N8  gnd  VDD
N9  gnd  VDD
N10  gnd  VDD
N11  gnd  VDD
N12  gnd  VDD
N13  gnd  VDDIO3
N14  gnd  VDDIO3
P1  gnd  nc
P2  gnd  VDDA18CSI
P3  gnd  VDDA18CSI
P4  gnd  VDDA18CSI
P5  nc  VDDA18CSI
P6  gnd  VDD
P7  gnd  VDD
P8  gnd  VDD
P9  gnd  VDD
P10  gnd  VDD
P11  gnd  VDD
P12  gnd  VDD
P13  gnd  VDDIO3
P14  gnd  nc
[Diff Pin]  inv_pin  vdiff  tdelay_typ  tdelay_min  tdelay_max
P3  N3  NA  NA  NA  NA
P4  N4  NA  NA  NA  NA
P2  N2  NA  NA  NA  NA
B5  A5  NA  NA  NA  NA
B2  A2  NA  NA  NA  NA
[Model Selector] DPHY_IBIS_L1
DPHY_RX_2P5G_L1   DPHY HSRX model at 2.5Gbps for lane 1
DPHY_RX_1P5G_L1   DPHY HSRX model at 1.5Gbps for lane 1
[Model Selector] io8_tt
io8_tt_ls_3v3 "GPIO - 3V tolerant - low speed - 3.3V range"
io8_tt_ms_3v3 "GPIO - 3V tolerant - med speed - 3.3V range"
io8_tt_fs_3v3 "GPIO - 3V tolerant - fast speed - 3.3V range"
io8_tt_hs_3v3 "GPIO - 3V tolerant - high speed - 3.3V range"
io8_tt_hslv_ls_1v8 "GPIO low voltage optimization - 3V tolerant - low speed - 1.8V range"
io8_tt_hslv_ms_1v8 "GPIO low voltage optimization - 3V tolerant - med speed - 1.8V range"
io8_tt_hslv_fs_1v8 "GPIO low voltage optimization - 3V tolerant - fast speed - 1.8V range"
io8_tt_hslv_hs_1v8 "GPIO low voltage optimization - 3V tolerant - high speed - 1.8V range"
[Model Selector] io8_tt_i3c
io8_tt_ls_3v3 "GPIO - 3V tolerant - low speed - 3.3V range"
io8_tt_ms_3v3 "GPIO - 3V tolerant - med speed - 3.3V range"
io8_tt_fs_3v3 "GPIO - 3V tolerant - fast speed - 3.3V range"
io8_tt_hs_3v3 "GPIO - 3V tolerant - high speed - 3.3V range"
io8_tt_hslv_ls_1v8 "GPIO low voltage optimization - 3V tolerant - low speed - 1.8V range"
io8_tt_hslv_ms_1v8 "GPIO low voltage optimization - 3V tolerant - med speed - 1.8V range"
io8_tt_hslv_fs_1v8 "GPIO low voltage optimization - 3V tolerant - fast speed - 1.8V range"
io8_tt_hslv_hs_1v8 "GPIO low voltage optimization - 3V tolerant - high speed - 1.8V range"
io8_tt_i3c_ls_3v3 "GPIO with I3C open-drain - 3V tolerant - low speed - 3.3V range"
io8_tt_i3c_ms_3v3 "GPIO with I3C open-drain - 3V tolerant - med speed - 3.3V range"
io8_tt_i3c_fs_3v3 "GPIO with I3C open-drain - 3V tolerant - fast speed - 3.3V range"
io8_tt_i3c_hs_3v3 "GPIO with I3C open-drain - 3V tolerant - high speed - 3.3V range"
io8_tt_hslv_i3c_ls_1v8 "GPIO low voltage optimization with I3C open-drain - 3V tolerant - low speed - 1.8V range"
io8_tt_hslv_i3c_ms_1v8 "GPIO low voltage optimization with I3C open-drain - 3V tolerant - med speed - 1.8V range"
io8_tt_hslv_i3c_fs_1v8 "GPIO low voltage optimization with I3C open-drain - 3V tolerant - fast speed - 1.8V range"
io8_tt_hslv_i3c_hs_1v8 "GPIO low voltage optimization with I3C open-drain - 3V tolerant - high speed - 1.8V range"
io8_tt_i3c_fmp_3v3 "GPIO with I3C fm+ open-drain - 3V tolerant - 3.3V range"
[Model Selector] io8_tt_sw
io8_tt_sw_3v3 "Input Buffer - 3V tolerant - 3.3V range"
io8_tt_sw_1v8 "Input Buffer - 3V tolerant - 1.8V range"
[Model Selector] io8_tt_tamp
io8_tt_ls_3v3 "GPIO - 3V tolerant - low speed - 3.3V range"
io8_tt_ms_3v3 "GPIO - 3V tolerant - med speed - 3.3V range"
io8_tt_fs_3v3 "GPIO - 3V tolerant - fast speed - 3.3V range"
io8_tt_hs_3v3 "GPIO - 3V tolerant - high speed - 3.3V range"
io8_tt_hslv_ls_1v8 "GPIO low voltage optimization - 3V tolerant - low speed - 1.8V range"
io8_tt_hslv_ms_1v8 "GPIO low voltage optimization - 3V tolerant - med speed - 1.8V range"
io8_tt_hslv_fs_1v8 "GPIO low voltage optimization - 3V tolerant - fast speed - 1.8V range"
io8_tt_hslv_hs_1v8 "GPIO low voltage optimization - 3V tolerant - high speed - 1.8V range"
io8_tt_tamp_3v3 "IO tamper - 3V tolerant - 3.3V range"
io8_tt_tamp_1v8 "IO tamper - 3V tolerant - 1.8V range"
|[Model Selector] ioreset_tt_v18
|ioreset_tt_v18_1v8 "Reset PAD - 3V tolerant - 1.8V range"
[Model Selector] isudq_tt
isudq_tt_3v3 "Input Buffer - 3V tolerant - 3.3V range"
isudq_tt_1v8 "Input Buffer - 3V tolerant - 1.8V range"
[Model Selector] USB2_HS_IBIS
USB2_HSRX   USB2 HSRX model
USB2_HSTX_00_0_01_0011_11   TuningBits_AMP_PULSE_RISE_REF_XV=00_0_01_0011_11
USB2_HSTX_00_0_10_0101_11   TuningBits_AMP_PULSE_RISE_REF_XV=00_0_10_0101_11
USB2_HSTX_00_0_11_0111_11   TuningBits_AMP_PULSE_RISE_REF_XV=00_0_11_0111_11
USB2_HSTX_00_1_01_0011_11   TuningBits_AMP_PULSE_RISE_REF_XV=00_1_01_0011_11
USB2_HSTX_00_1_10_0101_11   TuningBits_AMP_PULSE_RISE_REF_XV=00_1_10_0101_11
USB2_HSTX_00_1_11_0111_11   TuningBits_AMP_PULSE_RISE_REF_XV=00_1_11_0111_11
USB2_HSTX_01_0_01_0011_11   TuningBits_AMP_PULSE_RISE_REF_XV=01_0_01_0011_11
USB2_HSTX_01_0_10_0101_11   TuningBits_AMP_PULSE_RISE_REF_XV=01_0_10_0101_11
USB2_HSTX_01_0_11_0111_11   TuningBits_AMP_PULSE_RISE_REF_XV=01_0_11_0111_11
USB2_HSTX_01_1_01_0011_11   TuningBits_AMP_PULSE_RISE_REF_XV=01_1_01_0011_11
USB2_HSTX_01_1_10_0101_11   TuningBits_AMP_PULSE_RISE_REF_XV=01_1_10_0101_11
USB2_HSTX_01_1_11_0111_11   TuningBits_AMP_PULSE_RISE_REF_XV=01_1_11_0111_11
USB2_HSTX_10_0_01_0011_11   TuningBits_AMP_PULSE_RISE_REF_XV=10_0_01_0011_11
USB2_HSTX_10_0_10_0101_11   TuningBits_AMP_PULSE_RISE_REF_XV=10_0_10_0101_11
USB2_HSTX_10_0_11_0111_11   TuningBits_AMP_PULSE_RISE_REF_XV=10_0_11_0111_11
USB2_HSTX_10_1_01_0011_11   TuningBits_AMP_PULSE_RISE_REF_XV=10_1_01_0011_11
USB2_HSTX_10_1_10_0101_11   TuningBits_AMP_PULSE_RISE_REF_XV=10_1_10_0101_11
USB2_HSTX_10_1_11_0111_11   TuningBits_AMP_PULSE_RISE_REF_XV=10_1_11_0111_11
[Define Package Model]  486-fcvfbga-12x12-178-240308
[Manufacturer]  unknown
[OEM]  unknown
[Description]  unknown
[Number Of Pins]  153
[Pin Numbers]
| Pin Name Terminal   Net Name   Starting Node   Ending Node
D3 | BOOT0
N3 | CSI_CKN
P3 | CSI_CKP
N4 | CSI_D0N
P4 | CSI_D0P
N2 | CSI_D1N
P2 | CSI_D1P
N5 | CSI_REXT
E4 | NRST
A5 | OTG1_HSDM
B5 | OTG1_HSDP
B3 | OTG1_ID
D5 | OTG1_TXRTUNE
A3 | NC
A2 | OTG2_HSDM
B2 | OTG2_HSDP
C5 | OTG2_ID
B4 | OTG2_TXRTUNE
C4 | NC
P10 | PA0
L9 | PA1
N8 | PA2
K11 | PA3
M8 | PA5
L8 | PA6
P12 | PA7
P8 | PA8
M7 | PA9
N7 | PA10
M6 | PA11
L6 | PA12
P7 | PA13
P6 | PA14
N12 | PA15
G14 | PB0
E13 | PB2
E12 | PB3
L11 | PB4
M11 | PB5
H14 | PB6
H13 | PB7
P11 | PB10
L10 | PB11
M10 | PB12
B8 | PC1
A8 | PC6
A9 | PC7
C6 | PC8
D6 | PC9
D8 | PC10
C7 | PC11
D7 | PC12
C3 | PC13
B1 | PC14
C1 | PC15-OSC32_OUT
A12 | PD0
B12 | PD1
E10 | PD2
A13 | PD3
B13 | PD4
D14 | PD5
A11 | PD6
B11 | PD7
D13 | PD8
H12 | PD9
C11 | PD10
F11 | PD11
E11 | PD12
E14 | PD13
D12 | PD14
C12 | PD15
A1 | PDR_ON
F12 | PE0
F13 | PE1
F14 | PE2
G13 | PE3
D9 | PE5
A10 | PE6
D11 | PE7
C13 | PE8
B14 | PE9
C14 | PE10
B9 | PE11
D10 | PE12
C10 | PE13
C9 | PE14
B10 | PE15
K1 | PF2
J5 | PF3
J1 | PF4
J4 | PF5
J2 | PF6
K4 | PF7
L1 | PF8
J3 | PF10
L2 | PF11
L3 | PF12
M2 | PF13
K2 | PF14
K3 | PF15
M12 | PG0
M9 | PG1
N11 | PG2
L12 | PG8
N10 | PG10
N9 | PG12
P9 | PG13
L5 | PG14
M5 | PG15
B7 | PH0-OSC_IN
A7 | PH1-OSC_OUT
E6 | PH2
C8 | PH9
M13 | PN0
P13 | PN1
L13 | PN2
N13 | PN3
J13 | PN4
K14 | PN5
K12 | PN6
K13 | PN7
J14 | PN8
L14 | PN9
M14 | PN10
N14 | PN11
J12 | PN12
E3 | PWR_ON
A6 | UCPD1_CC1
B6 | UCPD1_CC2
D1 | V08CAP
C2 | VBAT
A4 | VDD33USB
G10 | VDD
M3 | VDDA18ADC
E5 | VDDA18AON
P5 | VDDA18CSI
L4 | VDDA18PLL
E1 | VDDA18PMU
D4 | VDDA18USB
K6 | VDDCORE
N6 | VDDCSI
J10 | VDDIO3
E8 | VDDIO4
H1 | VDDSMPS
D2 | VFBSMPS
G1 | VLXSMPS
N1 | VREFM
M1 | VREFP
A14 | VSS
M4 | VSSA
F5 | VSSAON
E2 | VSSAPMU
F1 | VSSSMPS
|[Merged Pins]  G10
|G11  |  VDD
|G12  |  VDD
|[Merged Pins]  K6
|K7  |  VDDCORE
|K8  |  VDDCORE
|K9  |  VDDCORE
|L7  |  VDDCORE
|[Merged Pins]  J10
|J11  |  VDDIO3
|[Merged Pins]  E8
|E9  |  VDDIO4
|[Merged Pins]  H1
|H2  |  VDDSMPS
|H3  |  VDDSMPS
|H4  |  VDDSMPS
|[Merged Pins]  G1
|G2  |  VLXSMPS
|G3  |  VLXSMPS
|G4  |  VLXSMPS
|[Merged Pins]  A14
|E7  |  VSS
|F10  |  VSS
|H10  |  VSS
|H11  |  VSS
|K5  |  VSS
|K10  |  VSS
|P1  |  VSS
|P14  |  VSS
|[Merged Pins]  F1
|F2  |  VSSSMPS
|F3  |  VSSSMPS
|F4  |  VSSSMPS
[Model Data]
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[End Model Data]
[End Package Model]
|End [Component]
| Models and submodels in the file (45): DPHY_RX_1P5G_L1 (Input), DPHY_RX_2P5G_L1 (Input), io8_tt_fs_3v3 (I/O), io8_tt_hs_3v3 (I/O), io8_tt_hslv_fs_1v8 (I/O), io8_tt_hslv_hs_1v8 (I/O), io8_tt_hslv_i3c_fs_1v8 (I/O_open_drain), io8_tt_hslv_i3c_hs_1v8 (I/O_open_drain), io8_tt_hslv_i3c_ls_1v8 (I/O_open_drain), io8_tt_hslv_i3c_ms_1v8 (I/O_open_drain), io8_tt_hslv_ls_1v8 (I/O), io8_tt_hslv_ms_1v8 (I/O), io8_tt_i3c_fmp_3v3 (I/O_open_drain), io8_tt_i3c_fs_3v3 (I/O_open_drain), io8_tt_i3c_hs_3v3 (I/O_open_drain), io8_tt_i3c_ls_3v3 (I/O_open_drain), io8_tt_i3c_ms_3v3 (I/O_open_drain), io8_tt_ls_3v3 (I/O), io8_tt_ms_3v3 (I/O), io8_tt_sw_1v8 (I/O), io8_tt_sw_3v3 (I/O), io8_tt_tamp_1v8 (I/O), io8_tt_tamp_3v3 (I/O), ioreset_tt_v18_1v8 (I/O_open_drain), isudq_tt_1v8 (Input), isudq_tt_3v3 (Input), USB2_HSRX (Input), USB2_HSTX_00_0_01_0011_11 (Output), USB2_HSTX_00_0_10_0101_11 (Output), USB2_HSTX_00_0_11_0111_11 (Output), USB2_HSTX_00_1_01_0011_11 (Output), USB2_HSTX_00_1_10_0101_11 (Output), USB2_HSTX_00_1_11_0111_11 (Output), USB2_HSTX_01_0_01_0011_11 (Output), USB2_HSTX_01_0_10_0101_11 (Output), USB2_HSTX_01_0_11_0111_11 (Output), USB2_HSTX_01_1_01_0011_11 (Output), USB2_HSTX_01_1_10_0101_11 (Output), USB2_HSTX_01_1_11_0111_11 (Output), USB2_HSTX_10_0_01_0011_11 (Output), USB2_HSTX_10_0_10_0101_11 (Output), USB2_HSTX_10_0_11_0111_11 (Output), USB2_HSTX_10_1_01_0011_11 (Output), USB2_HSTX_10_1_10_0101_11 (Output), USB2_HSTX_10_1_11_0111_11 (Output)
